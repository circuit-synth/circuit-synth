* ESP32_C6_Dev_Board_Main
* Generated by circuit-synth SPICE exporter

.title ESP32_C6_Dev_Board_Main

* Components

* SPICE Subcircuit Models
* AMS1117-3.3 Behavioral Model
.SUBCKT AMS1117_3V3 VI GND VO
* Simple regulation: VO = 3.3V when VI > 4V (dropout = 1.2V typical)
* Current limit: 1A maximum
E1 VO GND VALUE={IF(V(VI,GND) > 4.0, 3.3, V(VI,GND)-1.2)}
R1 VO GND 1MEG  ; Output impedance
G1 VI GND VALUE={I(E1)*1.2/V(VI,GND)}  ; Power dissipation model
.ENDS AMS1117_3V3

* ESP32-C6 Simplified Power Model
.SUBCKT ESP32_C6 VDD GND IO18 IO19 EN
* Power consumption: 200mA active, 10uA deep sleep
I1 VDD GND 200m  ; 200mA typical current draw
* GPIO behavioral models (simplified)
R18 IO18 GND 10k ; GPIO pull-up
R19 IO19 GND 10k
R_EN EN GND 10k  ; Enable pin pull-up
.ENDS ESP32_C6

* ESD Protection Diode
.SUBCKT ESD5Z A K
D1 A K D_ESD5V
.MODEL D_ESD5V D(IS=1e-14 BV=5.5 IBV=1e-3 CJO=50p)
.ENDS ESD5Z

* USB Connector Model (simplified)
.SUBCKT USB_CONN VBUS GND DP DM CC1 CC2 SHIELD
* CC resistors for device detection (5.1k pull-down)
R_CC1 CC1 GND 5.1k
R_CC2 CC2 GND 5.1k
* Shield connection
R_SHIELD SHIELD GND 1m  ; Shield to ground
* USB data lines (minimal model)
R_DP DP GND 1MEG  ; High impedance when not driven
R_DM DM GND 1MEG
.ENDS USB_CONN

* Voltage sources for analysis
VIN VIN 0 DC 5V  ; 5V USB power input

* Analysis commands
.DC VIN 3 6 0.1  ; Sweep input voltage
.AC DEC 10 0.1 1MEG
.TRAN 0 10m 0 10u  ; Transient analysis for load regulation

* Output requests
.PRINT DC V(VOUT) I(VIN)
.PRINT AC VDB(VOUT) VP(VOUT)
.PRINT TRAN V(VOUT) I(VIN)

.END
